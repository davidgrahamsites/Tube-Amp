Coupled transformer analytical fixture
VDRIVE DRIVE_P DRIVE_N DC 1 AC 30.822070014844883
RCT B_MAIN 0 1gig
RPA DRIVE_P PA_W 100
RPB PB_W DRIVE_N 100
LPA PA_W B_MAIN 10
LPB B_MAIN PB_W 10
LS SPEAKER 0 0.042105263157894736
KOT LPA LPB LS 1
RLOAD SPEAKER 0 8
.end
