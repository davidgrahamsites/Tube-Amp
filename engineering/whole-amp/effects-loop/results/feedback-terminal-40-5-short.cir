Terminal test
VDRIVE OT_PA OT_PB DC 0 AC 1
RCT B_MAIN 0 1gig
RPA OT_PA PA_W 100
RPB OT_PB PB_W 100
LPA PA_CORE B_MAIN 10.0
LPB B_MAIN PB_CORE 10.0
LS SPEAKER 0 0.042105263157894736
KOT LPA LPB LS 1
LLA PA_W PA_CORE 0.0025
LLB PB_CORE PB_W 0.0025
RTERM SPEAKER 0 1e-9
.end
