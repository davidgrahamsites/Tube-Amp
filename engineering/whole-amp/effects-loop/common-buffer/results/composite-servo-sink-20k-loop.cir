CB-002 composite recovery feasibility; generic MOS and ideal sink
.include "/Users/appleadmin/Documents/KiCad/Projects/Renegate Tube Amp with Reverb/engineering/solid-state-reverb/simulation/models/OPAx134.LIB"
.options method=gear reltol=0.0001 abstol=1n
VHV hv 0 400
VP vp 0 15
VN vn 0 -15
VIN vin 0 DC 2 AC 0 SIN(2 1.35 20000)
XERR pos inv vp vn err OPAx134
RINV vin inv 100000
RGATE err gate 10000
MGAIN drive gate 0 0 LNDgeneric
RDR hv drive 100000
MFOLLOW hv drive out out LNDgeneric
VCSREF csref 0 1
XCS csref sense vp vn csdrv OPAx134
RCSG csdrv csgate 1000
MSINK out csgate sense sense LNDgeneric
RSENSE sense 0 499
CGS3 csgate sense 9p
CGD3 csgate out 1p
CDS3 out sense 2.5p
RF out fb 990000
RG fb 0 10000
CF out fb 1p
COUT out load 1u
RLOAD load 0 340000
CLOAD load 0 100p
.model LNDgeneric NMOS (LEVEL=1 VTO=-2 KP=0.001 LAMBDA=0)
CGS1 gate 0 9p
CGD1 gate drive 1p
CDS1 drive 0 2.5p
CGS2 drive out 9p
CGD2 drive hv 1p
CDS2 hv out 2.5p
.nodeset v(out)=200 v(drive)=200 v(gate)=0 v(err)=0 v(fb)=2 v(inv)=2
CCOMP err inv 10p
LBRIDGE fb pos 1e9
CINJECT test pos 1e9
VTEST test 0 DC 0 AC 1
.end
