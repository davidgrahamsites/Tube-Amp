Renegade electric preamp headroom screen
.include "/Users/appleadmin/Documents/KiCad/Projects/Renegate Tube Amp with Reverb/engineering/whole-amp/simulation/models/dm12ax7s.inc"
.options method=gear maxord=2 reltol=0.0001 abstol=1p vntol=1u
VSUP B_EARLY 0 240
VPOST B_PRE 0 275
VSOURCE PICKUP 0 SIN(0 0.75 82.4)
RSOURCE PICKUP INPUT 20k
CCABLE INPUT 0 470p
R1 INPUT INPUT_STOP 68k
XV1_1 CL_P1 CL_IN CL_K1 12AX7A
R4 B_EARLY CL_P1 100k
R2 CL_IN 0 1meg
R3 CL_K1 0 1.5k
C1 CL_K1 0 25u
R5 CL_P1 CL_TONE 100k
C2 CL_P1 CL_TREBLE_TOP 250p
C3 CL_TONE CL_BASS_TOP 100n
C4 CL_TONE CL_BASS_BOTTOM 47n
RV1A CL_TREBLE_TOP CL_TREBLE_W 125000.0
RV1B CL_TREBLE_W CL_BASS_TOP 125000.0
RV2A CL_BASS_TOP CL_BASS_TOP 500000.0
RV2B CL_BASS_TOP CL_BASS_BOTTOM 500000.0
R6 CL_BASS_BOTTOM 0 15k
RV3A CL_TREBLE_W CL_G2 750000.0
RV3B CL_G2 0 250000.0
XV1_6 CL_P2 CL_G2 CL_K2 12AX7A
R7 B_EARLY CL_P2 100k
R8 CL_K2 0 1.5k
C5 CL_K2 0 25u
C6 CL_P2 CLEAN_OUT 47n
R43 CLEAN_OUT 0 10meg
RCONTACT INPUT_STOP SELECTED .05
VGRID SELECTED CL_IN 0
RLOAD CLEAN_OUT 0 1meg
.end
