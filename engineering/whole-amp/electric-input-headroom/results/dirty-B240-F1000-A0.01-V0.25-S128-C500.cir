Renegade electric preamp headroom screen
.include "/Users/appleadmin/Documents/KiCad/Projects/Renegate Tube Amp with Reverb/engineering/whole-amp/simulation/models/dm12ax7s.inc"
.options method=gear maxord=2 reltol=0.0001 abstol=1p vntol=1u
VSUP B_EARLY 0 240
VPOST B_PRE 0 275
VSOURCE PICKUP 0 SIN(0 0.01 1000)
RSOURCE PICKUP INPUT 20k
CCABLE INPUT 0 470p
R1 INPUT INPUT_STOP 68k
XV2_1 DR_P1 DR_IN DR_K1 12AX7A
R12 B_EARLY DR_P1 100k
R10 DR_IN 0 1meg
R11 DR_K1 0 2.7k
C7 DR_K1 0 680n
C8 DR_P1 DR_GAIN_TOP 22n
RV4A DR_GAIN_TOP DR_GAIN_W 500000.0
RV4B DR_GAIN_W 0 500000.0
R13 DR_GAIN_W DR_G2 470k
C9 DR_GAIN_W DR_G2 470p
R14 DR_G2 0 470k
XV2_6 DR_P2 DR_G2 DR_K2 12AX7A
R15 B_EARLY DR_P2 100k
R16 DR_K2 0 1.8k
C10 DR_K2 0 1u
C11 DR_P2 DR_C3 22n
R18 DR_C3 DR_G3 470k
R19 DR_G3 0 470k
XV3_1 DR_P3 DR_G3 DR_K3 12AX7A
R21 B_PRE DR_P3 100k
R20 DR_K3 0 820
C14 DR_K3 0 1u
XV3_6 B_PRE DR_P3 DR_CF 12AX7A
R22 DR_CF 0 100k
R23 DR_CF DR_TONE 33k
C15 DR_CF DR_TREBLE_TOP 470p
C16 DR_TONE DR_BASS_TOP 22n
C17 DR_TONE DR_BASS_BOTTOM 22n
RV5A DR_TREBLE_TOP DR_TREBLE_W 125000.0
RV5B DR_TREBLE_W DR_BASS_TOP 125000.0
RV6A DR_BASS_TOP DR_BASS_TOP 500000.0
RV6B DR_BASS_TOP DR_BASS_BOTTOM 500000.0
RV7A DR_BASS_BOTTOM 0 12500.0
RV7B 0 0 12500.0
RV8A DR_TREBLE_W DIRTY_OUT 750000.0
RV8B DIRTY_OUT 0 250000.0
RCONTACT INPUT_STOP SELECTED .05
VGRID SELECTED DR_IN 0
RLOAD DIRTY_OUT 0 1meg
.end
