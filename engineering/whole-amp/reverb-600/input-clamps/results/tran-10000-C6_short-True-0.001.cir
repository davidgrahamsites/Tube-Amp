Reverb input rail-injection bound; ideal clamp, no IC load
.options method=gear reltol=1e-6 abstol=1p vntol=1u
R601 IN_AC SEND_IN 980000
R602 SEND_IN 0 102000
BCP SEND_IN VP I=max(0,(v(SEND_IN)-v(VP)-0.5)/1)
BCN VN SEND_IN I=max(0,(v(VN)-v(SEND_IN)-0.5)/1)
C616 VP 0 3.76e-05 IC=15
C617 0 VN 3.76e-05 IC=15
RleakP VP 0 1e12
RleakN VN 0 1e12
BREGP 0 VP I=max(0,(15-v(VP))/1)
BREGN VN 0 I=max(0,(v(VN)-(-15))/1)
RloadP VP 0 10200.0
RloadN VN 0 10200.0
R7 B_EARLY CL_P2 100k
R43 CLEAN_OUT 0 10meg
C601 FX_RETURN IN_AC 100n
R612 FX_RETURN MIX_OUT 100k
R24 MIX_OUT 0 10meg
R616 OUT_BUF OUT_AC 100
C607 OUT_AC WET_AC 1u
R617 WET_AC 0 1meg
R618 WET_AC MIX_OUT 1meg
VFAULT CL_P2 CLEAN_OUT 0
VNORMAL CLEAN_OUT FX_RETURN 0
BOUTP OUT_BUF VP I=max(0,(v(OUT_BUF)-v(VP)-.5)/1)
BOUTN VN OUT_BUF I=max(0,(v(VN)-v(OUT_BUF)-.5)/1)
ROUTLEAK OUT_BUF 0 1e12
VPLATE B_EARLY 0 PWL(0 0 .1 0 .101 313 5 313 5.001 0 12 0)
.end
