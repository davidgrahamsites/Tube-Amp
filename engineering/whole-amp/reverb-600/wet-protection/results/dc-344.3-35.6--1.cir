Wet contact protection envelope; NOT a manufacturer Zener model
.options reltol=1e-7 abstol=1p vntol=1u method=gear
R7 PLATE FX_RETURN 100000
R43 FX_RETURN 0 10000000
R612 FX_RETURN MIX_OUT 100000
R24 MIX_OUT 0 10000000
R618 MIX_OUT WET_AC 1000000
R617 WET_AC 0 1000000
R616 OUT_BUF OUT_AC 100
C607 OUT_AC WET_AC 1e-06
C601 FX_RETURN IN_AC 1e-07
R601 IN_AC SEND_IN 1000000
R602 SEND_IN 0 100000
BCLAMP WET_AC 0 I=(max(v(WET_AC)-35.6,0)-max(-v(WET_AC)-35.6,0))/220
VP PLATE 0 -344.3
VW OUT_BUF 0 0
.end
