Passive reverb interface stress screen; no hardware qualification
.options method=gear reltol=1e-6 abstol=1p vntol=1u
C601 FX_RETURN IN_AC 1.0000000000000001e-07
R601 IN_AC SEND_IN 1000000.0
R602 SEND_IN 0 100000.0
R612 FX_RETURN MIX_OUT 100000.0
R616 OUT_BUF OUT_AC 100.0
C607 OUT_AC WET_AC 1e-06
R617 WET_AC 0 1000000.0
R618 WET_AC MIX_OUT 1000000.0
R24 MIX_OUT 0 10000000.0
R7 B_EARLY CL_P2 100000.0
C6 CL_P2 CLEAN_OUT 4.7000000000000004e-08
R43 CLEAN_OUT 0 10000000.0
VNORMAL CLEAN_OUT FX_RETURN 0
VPLATE B_EARLY 0 PWL(0 0 .1 0 0.101 278 3 278 3.001 0 8 0)
VWET OUT_BUF 0 -15
.end
