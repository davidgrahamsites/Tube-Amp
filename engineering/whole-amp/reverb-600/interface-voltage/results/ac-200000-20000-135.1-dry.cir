Passive reverb interface stress screen; no hardware qualification
.options method=gear reltol=1e-6 abstol=1p vntol=1u
C601 FX_RETURN IN_AC 1.0000000000000001e-07
R601 IN_AC SEND_IN 1000000.0
R602 SEND_IN 0 100000.0
R612 FX_RETURN MIX_OUT 100000.0
R616 OUT_BUF OUT_AC 100.0
C607 OUT_AC WET_AC 1e-06
R617 WET_AC 0 1000000.0
R618 WET_AC MIX_OUT 1000000.0
R24 MIX_OUT 0 10000000.0
VDRY DRIVE 0 DC 0 AC 135.1
RSOURCE DRIVE FX_RETURN 200000
VWET OUT_BUF 0 DC 0 AC 0
.end
