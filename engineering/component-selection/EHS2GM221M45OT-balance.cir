Reservoir static leakage corner: EHS2GM221M45OT
V1 raw 0 510.31
R501 raw mid 209000.0
R502 mid 0 231000.0
C29 raw mid 220u
C30 mid 0 220u
I29 raw mid 0.0017850000000000001
I30 mid 0 0
.end
