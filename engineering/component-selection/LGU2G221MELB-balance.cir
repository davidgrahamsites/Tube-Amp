Reservoir static leakage corner: LGU2G221MELB
V1 raw 0 510.31
R501 raw mid 231000.0
R502 mid 0 209000.0
C29 raw mid 220u
C30 mid 0 220u
I29 raw mid 0
I30 mid 0 0.0008899438184514795
.end
