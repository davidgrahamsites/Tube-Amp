Renegade reciprocal tapped-secondary experiment; NOT selected magnetics
.include "/Users/appleadmin/Documents/KiCad/Projects/Renegate Tube Amp with Reverb/engineering/whole-amp/simulation/models/dm12ax7s.inc"
* Local numerical domain guard at Bgs2; see solver-review.md
*-----------------------------------------------------------------------
* Filename:		6ca7s.inc  19/5/97  V1
* Simulator:		Spice 3f4
* Device type:		Power pentode
* Device model:		6CA7/EL34
*
* Author:		Duncan Munro
* Date:			19/5/97
* Copyright:		(C)1997-2000 Duncan Amplification
*
* The following parameters are not modelled:
*
*   (1) Heater
*   (2) Grid current is an approximation
*
* Please note that this model is provided "as is" and
* no warranty is provided in respect of its suitability
* for any application.
*
* This model is provided for educational and non-profit use.
*
* Email queries to postmaster@duncanamps.com
*
* Pins   A  Anode
*        S  Screen
*        G  Grid
*        K  Cathode
*
*-----------------------------------------------------------------------

.SUBCKT 6CA7 A S G K
*
* Calculate contribution to cathode current
*
Bat	at  0	V=0.636*ATAN(V(A,K)/23)
Bgs	gs  0	V=URAMP(V(S,K)/9.3+V(G,K)*0.95)
Bgs2	gs2 0	V=URAMP(V(gs))^1.5
Bcath	cc  0	V=V(gs2)*V(at)
*
* Calculate anode current
*
Ba	A   K	I=1.86E-3*V(cc)
*
* Calculate screen current
*
Bscrn	sc  0	V=V(gs2)*(1.1-V(at))
Bs	S   K	I=1.518E-3*V(sc)
*
* Grid current (approximation - does not model low va/vs)
*
Bg	G   K	I=(URAMP(V(G,K)+1)^1.5)*50E-6
*
* Capacitances
*
Cg1	G	K	15.4p
Cak	A	K	8.4p
Cg1a	G	A	1.1p

.ENDS
.options method=gear maxord=2 reltol=0.001 abstol=1n vntol=10u gmin=1e-10 rshunt=1e12 cshunt=1e-14
R17 B_PRE B_EARLY 10000
C12 B_EARLY 0 50u
RFEED SUPPLY_IN PREREG 570
VPRE REG_OUT B_PRE 0
BREG PREREG REG_OUT I=max(0,min(0.03,min((V(PREREG)-V(REG_OUT)-10)/100,(292.15634765829145-V(REG_OUT))/.1)))
VMAIN B_MAIN 0 400
VSCREEN B_SCREEN 0 380
VBIAS BIAS_OUT 0 -40
VSOURCE PICKUP 0 DC 0 AC 0 SIN(0 0.009 1000)
RSOURCE PICKUP INPUT 20k
CCABLE INPUT 0 470p
VWET OUT_BUF 0 DC 0 AC 0
VTEST RET_DRIVE 0 DC 0 AC 1
XV1_1 CL_P1 CL_IN CL_K1 12AX7A
R4 B_EARLY CL_P1 100000.0
R2 CL_IN 0 1000000.0
R3 CL_K1 0 1500.0
C1 CL_K1 0 2.4999999999999998e-05
R5 CL_P1 CL_TONE 100000.0
C2 CL_P1 CL_TREBLE_TOP 2.5e-10
C3 CL_TONE CL_BASS_TOP 1.0000000000000001e-07
C4 CL_TONE CL_BASS_BOTTOM 4.7000000000000004e-08
RV1A CL_TREBLE_TOP CL_TREBLE_W 125000.0
RV1B CL_TREBLE_W CL_BASS_TOP 125000.0
RV2A CL_BASS_TOP CL_BASS_TOP 500000.0
RV2B CL_BASS_TOP CL_BASS_BOTTOM 500000.0
R6 CL_BASS_BOTTOM 0 15000.0
RV3A CL_TREBLE_W CL_G2 1
RV3B CL_G2 0 1000000.0
XV1_6 CL_P2 CL_G2 CL_K2 12AX7A
R7 B_EARLY CL_P2 100000.0
R8 CL_K2 0 1500.0
C5 CL_K2 0 2.4999999999999998e-05
C6 CL_P2 CLEAN_OUT 4.7000000000000004e-08
R43 CLEAN_OUT 0 10000000.0
XV2_1 DR_P1 DR_IN DR_K1 12AX7A
R12 B_EARLY DR_P1 100000.0
R10 DR_IN 0 1000000.0
R11 DR_K1 0 2700.0
C7 DR_K1 0 6.800000000000001e-07
C8 DR_P1 DR_GAIN_TOP 2.2000000000000002e-08
RV4A DR_GAIN_TOP DR_GAIN_W 500000.0
RV4B DR_GAIN_W 0 500000.0
R13 DR_GAIN_W DR_G2 470000.0
C9 DR_GAIN_W DR_G2 4.7e-10
R14 DR_G2 0 470000.0
XV2_6 DR_P2 DR_G2 DR_K2 12AX7A
R15 B_EARLY DR_P2 100000.0
R16 DR_K2 0 1800.0
C10 DR_K2 0 1e-06
C11 DR_P2 DR_C3 2.2000000000000002e-08
R18 DR_C3 DR_G3 470000.0
R19 DR_G3 0 470000.0
XV3_1 DR_P3 DR_G3 DR_K3 12AX7A
R21 B_PRE DR_P3 100000.0
R20 DR_K3 0 820.0
C14 DR_K3 0 1e-06
XV3_6 B_PRE DR_P3 DR_CF 12AX7A
R22 DR_CF 0 100000.0
R23 DR_CF DR_TONE 33000.0
C15 DR_CF DR_TREBLE_TOP 4.7e-10
C16 DR_TONE DR_BASS_TOP 2.2000000000000002e-08
C17 DR_TONE DR_BASS_BOTTOM 2.2000000000000002e-08
RV5A DR_TREBLE_TOP DR_TREBLE_W 125000.0
RV5B DR_TREBLE_W DR_BASS_TOP 125000.0
RV6A DR_BASS_TOP DR_BASS_TOP 500000.0
RV6B DR_BASS_TOP DR_BASS_BOTTOM 500000.0
RV7A DR_BASS_BOTTOM 0 12500.0
RV7B 0 0 12500.0
RV8A DR_TREBLE_W DIRTY_OUT 1
RV8B DIRTY_OUT 0 1000000.0
R1 INPUT INPUT_STOP 68000.0
R24 MIX_OUT 0 10000000.0
C19 MIX_OUT PI_G1 2.2000000000000002e-08
R25 PI_G1 PI_TAIL_TOP 1000000.0
XV4_1 PI_P1 PI_G1 PI_K 12AX7A
XV4_6 PI_P2 PI_G2 PI_K 12AX7A
R29 B_PRE PI_P1 82000.0
R30 B_PRE PI_P2 100000.0
C22 PI_P1 PI_P2 4.7e-11
R26 PI_K PI_TAIL_TOP 470.0
R28 PI_TAIL_TOP NFB_NODE 10000.0
R27 PI_G2 PI_TAIL_TOP 1000000.0
C20 PI_G2 NFB_NODE 1.0000000000000001e-07
R31 OT_4 NFB_NODE 100000.0
R32 NFB_NODE 0 47000.0
C21 NFB_NODE PRES_TOP 1.0000000000000001e-07
RV9A PRES_TOP 0 12500.0
RV9B 0 0 12500.0
C23 PI_P1 GRID_A_FEED 2.2000000000000002e-08
C24 PI_P2 GRID_B_FEED 2.2000000000000002e-08
R33 GRID_A_FEED BIAS_OUT 220000.0
R34 GRID_B_FEED BIAS_OUT 220000.0
R36 GRID_A_FEED EL34_GA 1500.0
R37 GRID_B_FEED EL34_GB 1500.0
R41 B_SCREEN EL34_SA 4700.0
R42 B_SCREEN EL34_SB 4700.0
XV5_3 OT_PA EL34_SA EL34_GA K_A 6CA7
XV6_3 OT_PB EL34_SB EL34_GB K_B 6CA7
R110 K_A 0 1.0
R111 K_B 0 1.0
C601 FX_RETURN IN_AC 1.0000000000000001e-07
R601 IN_AC SEND_IN 1000000.0
R602 SEND_IN 0 100000.0
R612 FX_RETURN MIX_OUT 100000.0
R616 OUT_BUF OUT_AC 100.0
C607 OUT_AC WET_AC 1e-06
R617 WET_AC 0 1000000.0
R618 WET_AC MIX_OUT 1000000.0
RK1A INPUT_STOP CL_IN .05
RK1B DR_G2 0 .05
RK2 CLEAN_OUT FX_SEND .05
RBUF_IN FX_SEND 0 1meg
EBUF BUF_OUT 0 FX_SEND 0 1
RBUF_OUT BUF_OUT FX_RETURN 1000
RPA OT_PA PA_W 100
RPB OT_PB PB_W 100
RLOAD SPEAKER 0 8.0
LPA PA_CORE B_MAIN 10.0
LPB B_MAIN PB_CORE 10.0
LLA PA_W PA_CORE 0.01
LLB PB_CORE PB_W 0.01
CPR PA_W PB_W 2.5e-10
LSLOW TAP_CORE 0 0.021052631578947364
LSHIGH SEC_HIGH OT_4 0.0036120605316591575
KOT LPA LPB LSLOW LSHIGH 1
RSLOW TAP_CORE OT_4 0.1414213562373095
RSHIGH SEC_HIGH SPEAKER 0.05857864376269051
RHT B_PRE HREF 39000
RHB HREF 0 39000
C13 B_PRE 0 50u
C25 B_PRE 0 50u
RPROGRAM B_PRE 0 43615
IPROGRAM B_PRE 0 4.6082769689327066e-07
VSUPPLY SUPPLY_IN 0 550
.end
