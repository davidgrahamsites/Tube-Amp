HD-003 compensated heater reference; allocated values only
VB BPRE 0 PWL(0.0 0 0.01 0 0.01001 300 0.1 300 0.10001 0 0.2 0 0.3 300 0.4 300 0.45 0 0.45001 300 0.46 300 0.46001 0 0.6 0)
RT BPRE HREF 40950.0
RB HREF 0 40950.0
CT BPRE HREF 1.1e-07
CB HREF 0 1.1e-07
.end
